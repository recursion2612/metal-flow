# Ansys Electronics Desktop project, version 2025.1
materials:
  vacuum: permittivity=1
  pec: conductivity=1e+30
  silicon: permittivity=11.9

design feedline_02_drivenmodal (HFSS, HFSS Modal Network, model units mm)
variables:
  Lj = 10nH
  Cj = 0fF
geometry:
  trace_feedline_02_path = polyline((0.00025, 0.00845, 0) (0.00025, 0.00205, 0))
  trace_feedline_02 = polyline((0.000255, 0.00845, 0) (0.000245, 0.00845, 0))
  trace_feedline_02.sweep_along_path(trace_feedline_02_path)
  cut_feedline_02_path = polyline((0.00025, 0.00845, 0) (0.00025, 0.00205, 0))
  cut_feedline_02 = polyline((0.000261, 0.00845, 0) (0.000239, 0.00845, 0))
  cut_feedline_02.sweep_along_path(cut_feedline_02_path)
  g_wb [pec] = bondwire(WireType=LOW WireDiameter=0.015mm NumSides=6 XPadPos=0.000195 YPadPos=0.0080735294 ZPadPos=0 XDir=1 YDir=0 ZDir=0 Distance=0.00011 h1=0.00011 h2=0mm alpha=80deg beta=80deg WhichAxis=Z)
  g_wb_1 [pec] = bondwire(WireType=LOW WireDiameter=0.015mm NumSides=6 XPadPos=0.000195 YPadPos=0.0076970588 ZPadPos=0 XDir=1 YDir=0 ZDir=0 Distance=0.00011 h1=0.00011 h2=0mm alpha=80deg beta=80deg WhichAxis=Z)
  g_wb_2 [pec] = bondwire(WireType=LOW WireDiameter=0.015mm NumSides=6 XPadPos=0.000195 YPadPos=0.0073205882 ZPadPos=0 XDir=1 YDir=0 ZDir=0 Distance=0.00011 h1=0.00011 h2=0mm alpha=80deg beta=80deg WhichAxis=Z)
  g_wb_3 [pec] = bondwire(WireType=LOW WireDiameter=0.015mm NumSides=6 XPadPos=0.000195 YPadPos=0.0069441176 ZPadPos=0 XDir=1 YDir=0 ZDir=0 Distance=0.00011 h1=0.00011 h2=0mm alpha=80deg beta=80deg WhichAxis=Z)
  g_wb_4 [pec] = bondwire(WireType=LOW WireDiameter=0.015mm NumSides=6 XPadPos=0.000195 YPadPos=0.0065676471 ZPadPos=0 XDir=1 YDir=0 ZDir=0 Distance=0.00011 h1=0.00011 h2=0mm alpha=80deg beta=80deg WhichAxis=Z)
  g_wb_5 [pec] = bondwire(WireType=LOW WireDiameter=0.015mm NumSides=6 XPadPos=0.000195 YPadPos=0.0061911765 ZPadPos=0 XDir=1 YDir=0 ZDir=0 Distance=0.00011 h1=0.00011 h2=0mm alpha=80deg beta=80deg WhichAxis=Z)
  g_wb_6 [pec] = bondwire(WireType=LOW WireDiameter=0.015mm NumSides=6 XPadPos=0.000195 YPadPos=0.0058147059 ZPadPos=0 XDir=1 YDir=0 ZDir=0 Distance=0.00011 h1=0.00011 h2=0mm alpha=80deg beta=80deg WhichAxis=Z)
  g_wb_7 [pec] = bondwire(WireType=LOW WireDiameter=0.015mm NumSides=6 XPadPos=0.000195 YPadPos=0.0054382353 ZPadPos=0 XDir=1 YDir=0 ZDir=0 Distance=0.00011 h1=0.00011 h2=0mm alpha=80deg beta=80deg WhichAxis=Z)
  g_wb_8 [pec] = bondwire(WireType=LOW WireDiameter=0.015mm NumSides=6 XPadPos=0.000195 YPadPos=0.0050617647 ZPadPos=0 XDir=1 YDir=0 ZDir=0 Distance=0.00011 h1=0.00011 h2=0mm alpha=80deg beta=80deg WhichAxis=Z)
  g_wb_9 [pec] = bondwire(WireType=LOW WireDiameter=0.015mm NumSides=6 XPadPos=0.000195 YPadPos=0.0046852941 ZPadPos=0 XDir=1 YDir=0 ZDir=0 Distance=0.00011 h1=0.00011 h2=0mm alpha=80deg beta=80deg WhichAxis=Z)
  g_wb_10 [pec] = bondwire(WireType=LOW WireDiameter=0.015mm NumSides=6 XPadPos=0.000195 YPadPos=0.0043088235 ZPadPos=0 XDir=1 YDir=0 ZDir=0 Distance=0.00011 h1=0.00011 h2=0mm alpha=80deg beta=80deg WhichAxis=Z)
  g_wb_11 [pec] = bondwire(WireType=LOW WireDiameter=0.015mm NumSides=6 XPadPos=0.000195 YPadPos=0.0039323529 ZPadPos=0 XDir=1 YDir=0 ZDir=0 Distance=0.00011 h1=0.00011 h2=0mm alpha=80deg beta=80deg WhichAxis=Z)
  g_wb_12 [pec] = bondwire(WireType=LOW WireDiameter=0.015mm NumSides=6 XPadPos=0.000195 YPadPos=0.0035558824 ZPadPos=0 XDir=1 YDir=0 ZDir=0 Distance=0.00011 h1=0.00011 h2=0mm alpha=80deg beta=80deg WhichAxis=Z)
  g_wb_13 [pec] = bondwire(WireType=LOW WireDiameter=0.015mm NumSides=6 XPadPos=0.000195 YPadPos=0.0031794118 ZPadPos=0 XDir=1 YDir=0 ZDir=0 Distance=0.00011 h1=0.00011 h2=0mm alpha=80deg beta=80deg WhichAxis=Z)
  g_wb_14 [pec] = bondwire(WireType=LOW WireDiameter=0.015mm NumSides=6 XPadPos=0.000195 YPadPos=0.0028029412 ZPadPos=0 XDir=1 YDir=0 ZDir=0 Distance=0.00011 h1=0.00011 h2=0mm alpha=80deg beta=80deg WhichAxis=Z)
  g_wb_15 [pec] = bondwire(WireType=LOW WireDiameter=0.015mm NumSides=6 XPadPos=0.000195 YPadPos=0.0024264706 ZPadPos=0 XDir=1 YDir=0 ZDir=0 Distance=0.00011 h1=0.00011 h2=0mm alpha=80deg beta=80deg WhichAxis=Z)
  launch_pad_p0 = polyline(z=0, xy: (0.000255, 0.0085) (0.00029, 0.008622) (0.00029, 0.008702) (0.00021, 0.008702) (0.00021, 0.008622) (0.000245, 0.0085) (0.000245, 0.00845) (0.000255, 0.00845) (0.000255, 0.0085), closed, covered)
  pocket_p0 = polyline(z=0, xy: (0.000261, 0.0085) (0.000348, 0.008622) (0.000348, 0.00876) (0.000152, 0.00876) (0.000152, 0.008622) (0.000239, 0.0085) (0.000239, 0.00845) (0.000261, 0.00845) (0.000261, 0.0085), closed, covered)
  launch_pad_p2 = polyline(z=0, xy: (0.000245, 0.002) (0.00021, 0.001878) (0.00021, 0.001798) (0.00029, 0.001798) (0.00029, 0.001878) (0.000255, 0.002) (0.000255, 0.00205) (0.000245, 0.00205) (0.000245, 0.002), closed, covered)
  pocket_p2 = polyline(z=0, xy: (0.000239, 0.002) (0.000152, 0.001878) (0.000152, 0.00174) (0.000348, 0.00174) (0.000348, 0.001878) (0.000261, 0.002) (0.000261, 0.00205) (0.000239, 0.00205) (0.000239, 0.002), closed, covered)
  endcap_p0_in = rectangle(corner=(0.000152, 0.008702, 0), x_size=0.000196, y_size=5.8e-05)
  endcap_p2_in = rectangle(corner=(0.000152, 0.00174, 0), x_size=0.000196, y_size=5.8e-05)
  ground_main_plane = rectangle(corner=(-4.8e-05, 0.00154, 0), x_size=0.000596, y_size=0.00742)
  main [silicon] = box(corner=(-4.8e-05, 0.00154, -0.00028), size=(0.000596, 0.00742, 0.00028))
  sample_holder [vacuum] = box(corner=(-4.8e-05, 0.00154, -0.00165), size=(0.000596, 0.00742, 0.00254))
  ground_main_plane.subtract(endcap_p0_in, endcap_p2_in, cut_feedline_02, pocket_p2, pocket_p0)
  Port_p0_in = rectangle(corner=(0.00021, 0.008702, 0), x_size=8e-05, y_size=5.8e-05)
  voltage_line_Port_p0_in = polyline((0.00025, 0.00876, 0) (0.00025, 0.008702, 0))
  Port_p2_in = rectangle(corner=(0.00021, 0.00174, 0), x_size=8e-05, y_size=5.8e-05)
  voltage_line_Port_p2_in = polyline((0.00025, 0.00174, 0) (0.00025, 0.001798, 0))
boundaries and excitations:
  PerfE: Perfect E Objects=[trace_feedline_02, launch_pad_p0, launch_pad_p2, ground_main_plane]
  LumpPort_p0_in: Lumped Port Objects=Port_p0_in LumpedPortType=Modal Modes{Mode1{IntLine{(0.25, 8.702, 0) -> (0.25, 8.76, 0)} CharImp=Zpi RenormImp=50ohm}} Impedance=50ohm
  LumpPort_p2_in: Lumped Port Objects=Port_p2_in LumpedPortType=Modal Modes{Mode1{IntLine{(0.25, 1.74, 0) -> (0.25, 1.798, 0)} CharImp=Zpi RenormImp=50ohm}} Impedance=50ohm
setups:
  Setup: HfssDriven Frequency=6GHz MaxDeltaS=0.001 MaximumPasses=35 MinimumPasses=1 MinimumConvergedPasses=2 PercentRefinement=30 BasisOrder=-1 PortAccuracy=2 DrivenSolverType="Direct Solver"
    sweep Sweep: 2GHz to 10GHz, 10001 points; Type=Interpolating SaveFields InterpTolerance=0.5 InterpMaxSolns=250 InterpUsePortImped=false PassivityErrorTolerance=0.0001
source amplitudes:
  LumpPort_p0_in:1: 1W 0deg
  LumpPort_p2_in:1: 0W 0deg
field plots:
  Mag_E1: E Field over Port_p0_in.face Port_p2_in.face trace_feedline_02.face launch_pad_p0.face launch_pad_p2.face on Setup : LastAdaptive at Freq=6GHz Phase=0deg
  Mag_E2: E Field over ground_main_plane.face(at (0.25, 5.25, 0)) on Setup : LastAdaptive at Freq=6GHz Phase=0deg
  Mesh1: MeshPlots over ground_main_plane.face(at (0.25, 5.25, 0)) on Setup : LastAdaptive at Freq=6GHz Phase=0deg
  Mesh2: MeshPlots over Port_p0_in.face Port_p2_in.face launch_pad_p0.face launch_pad_p2.face trace_feedline_02.face on Setup : LastAdaptive at Freq=6GHz Phase=0deg
reports:
  S Parameter Plot1: dB(S(LumpPort_p0_in,LumpPort_p0_in)), dB(S(LumpPort_p2_in,LumpPort_p0_in)) vs Freq on Setup : Sweep
  S Parameter Plot2: ang_deg(S(LumpPort_p0_in,LumpPort_p0_in)), ang_deg(S(LumpPort_p2_in,LumpPort_p0_in)) vs Freq on Setup : Sweep
  Y Parameter Plot1: dB20normalize(Y(LumpPort_p0_in,LumpPort_p0_in)), dB20normalize(Y(LumpPort_p2_in,LumpPort_p0_in)) vs Freq on Setup : Sweep
  Y Parameter Plot2: ang_deg(Y(LumpPort_p0_in,LumpPort_p0_in)), ang_deg(Y(LumpPort_p2_in,LumpPort_p0_in)) vs Freq on Setup : Sweep
  Z Parameter Plot1: dB20normalize(Z(LumpPort_p0_in,LumpPort_p0_in)), dB20normalize(Z(LumpPort_p2_in,LumpPort_p0_in)) vs Freq on Setup : Sweep
  Z Parameter Plot2: ang_deg(Z(LumpPort_p0_in,LumpPort_p0_in)), ang_deg(Z(LumpPort_p2_in,LumpPort_p0_in)) vs Freq on Setup : Sweep
  VSWR Plot1: dB(VSWR(LumpPort_p0_in)), dB(VSWR(LumpPort_p2_in)) vs Freq on Setup : Sweep

design feedline_02_eigenmode (HFSS, Eigenmode, model units mm)
geometry:
  trace_feedline_02 = polyline((0.000255, 0.00845, 0) (0.000245, 0.00845, 0))
  trace_feedline_02_path = polyline((0.00025, 0.00845, 0) (0.00025, 0.00205, 0))
  trace_feedline_02.sweep_along_path(trace_feedline_02_path)
  launch_pad_p0 = polyline(z=0, xy: (0.000255, 0.0085) (0.00029, 0.008622) (0.00029, 0.008702) (0.00021, 0.008702) (0.00021, 0.008622) (0.000245, 0.0085) (0.000245, 0.00845) (0.000255, 0.00845) (0.000255, 0.0085), closed, covered)
  launch_pad_p2 = polyline(z=0, xy: (0.000245, 0.002) (0.00021, 0.001878) (0.00021, 0.001798) (0.00029, 0.001798) (0.00029, 0.001878) (0.000255, 0.002) (0.000255, 0.00205) (0.000245, 0.00205) (0.000245, 0.002), closed, covered)
  ground_main_plane = rectangle(corner=(-4.8e-05, 0.00154, 0), x_size=0.000596, y_size=0.00742)
  endcap_p0_in = rectangle(corner=(0.000152, 0.008702, 0), x_size=0.000196, y_size=5.8e-05)
  endcap_p2_in = rectangle(corner=(0.000152, 0.00174, 0), x_size=0.000196, y_size=5.8e-05)
  cut_feedline_02 = polyline((0.000261, 0.00845, 0) (0.000239, 0.00845, 0))
  cut_feedline_02_path = polyline((0.00025, 0.00845, 0) (0.00025, 0.00205, 0))
  cut_feedline_02.sweep_along_path(cut_feedline_02_path)
  pocket_p2 = polyline(z=0, xy: (0.000239, 0.002) (0.000152, 0.001878) (0.000152, 0.00174) (0.000348, 0.00174) (0.000348, 0.001878) (0.000261, 0.002) (0.000261, 0.00205) (0.000239, 0.00205) (0.000239, 0.002), closed, covered)
  pocket_p0 = polyline(z=0, xy: (0.000261, 0.0085) (0.000348, 0.008622) (0.000348, 0.00876) (0.000152, 0.00876) (0.000152, 0.008622) (0.000239, 0.0085) (0.000239, 0.00845) (0.000261, 0.00845) (0.000261, 0.0085), closed, covered)
  ground_main_plane.subtract(endcap_p0_in, endcap_p2_in, cut_feedline_02, pocket_p2, pocket_p0)
  g_wb [pec] = bondwire(WireType=LOW WireDiameter=0.015mm NumSides=6 XPadPos=0.000195 YPadPos=0.0080735294 ZPadPos=0 XDir=1 YDir=0 ZDir=0 Distance=0.00011 h1=0.00011 h2=0mm alpha=80deg beta=80deg WhichAxis=Z)
  g_wb_1 [pec] = bondwire(WireType=LOW WireDiameter=0.015mm NumSides=6 XPadPos=0.000195 YPadPos=0.0076970588 ZPadPos=0 XDir=1 YDir=0 ZDir=0 Distance=0.00011 h1=0.00011 h2=0mm alpha=80deg beta=80deg WhichAxis=Z)
  g_wb_2 [pec] = bondwire(WireType=LOW WireDiameter=0.015mm NumSides=6 XPadPos=0.000195 YPadPos=0.0073205882 ZPadPos=0 XDir=1 YDir=0 ZDir=0 Distance=0.00011 h1=0.00011 h2=0mm alpha=80deg beta=80deg WhichAxis=Z)
  g_wb_3 [pec] = bondwire(WireType=LOW WireDiameter=0.015mm NumSides=6 XPadPos=0.000195 YPadPos=0.0069441176 ZPadPos=0 XDir=1 YDir=0 ZDir=0 Distance=0.00011 h1=0.00011 h2=0mm alpha=80deg beta=80deg WhichAxis=Z)
  g_wb_4 [pec] = bondwire(WireType=LOW WireDiameter=0.015mm NumSides=6 XPadPos=0.000195 YPadPos=0.0065676471 ZPadPos=0 XDir=1 YDir=0 ZDir=0 Distance=0.00011 h1=0.00011 h2=0mm alpha=80deg beta=80deg WhichAxis=Z)
  g_wb_5 [pec] = bondwire(WireType=LOW WireDiameter=0.015mm NumSides=6 XPadPos=0.000195 YPadPos=0.0061911765 ZPadPos=0 XDir=1 YDir=0 ZDir=0 Distance=0.00011 h1=0.00011 h2=0mm alpha=80deg beta=80deg WhichAxis=Z)
  g_wb_6 [pec] = bondwire(WireType=LOW WireDiameter=0.015mm NumSides=6 XPadPos=0.000195 YPadPos=0.0058147059 ZPadPos=0 XDir=1 YDir=0 ZDir=0 Distance=0.00011 h1=0.00011 h2=0mm alpha=80deg beta=80deg WhichAxis=Z)
  g_wb_7 [pec] = bondwire(WireType=LOW WireDiameter=0.015mm NumSides=6 XPadPos=0.000195 YPadPos=0.0054382353 ZPadPos=0 XDir=1 YDir=0 ZDir=0 Distance=0.00011 h1=0.00011 h2=0mm alpha=80deg beta=80deg WhichAxis=Z)
  g_wb_8 [pec] = bondwire(WireType=LOW WireDiameter=0.015mm NumSides=6 XPadPos=0.000195 YPadPos=0.0050617647 ZPadPos=0 XDir=1 YDir=0 ZDir=0 Distance=0.00011 h1=0.00011 h2=0mm alpha=80deg beta=80deg WhichAxis=Z)
  g_wb_9 [pec] = bondwire(WireType=LOW WireDiameter=0.015mm NumSides=6 XPadPos=0.000195 YPadPos=0.0046852941 ZPadPos=0 XDir=1 YDir=0 ZDir=0 Distance=0.00011 h1=0.00011 h2=0mm alpha=80deg beta=80deg WhichAxis=Z)
  g_wb_10 [pec] = bondwire(WireType=LOW WireDiameter=0.015mm NumSides=6 XPadPos=0.000195 YPadPos=0.0043088235 ZPadPos=0 XDir=1 YDir=0 ZDir=0 Distance=0.00011 h1=0.00011 h2=0mm alpha=80deg beta=80deg WhichAxis=Z)
  g_wb_11 [pec] = bondwire(WireType=LOW WireDiameter=0.015mm NumSides=6 XPadPos=0.000195 YPadPos=0.0039323529 ZPadPos=0 XDir=1 YDir=0 ZDir=0 Distance=0.00011 h1=0.00011 h2=0mm alpha=80deg beta=80deg WhichAxis=Z)
  g_wb_12 [pec] = bondwire(WireType=LOW WireDiameter=0.015mm NumSides=6 XPadPos=0.000195 YPadPos=0.0035558824 ZPadPos=0 XDir=1 YDir=0 ZDir=0 Distance=0.00011 h1=0.00011 h2=0mm alpha=80deg beta=80deg WhichAxis=Z)
  g_wb_13 [pec] = bondwire(WireType=LOW WireDiameter=0.015mm NumSides=6 XPadPos=0.000195 YPadPos=0.0031794118 ZPadPos=0 XDir=1 YDir=0 ZDir=0 Distance=0.00011 h1=0.00011 h2=0mm alpha=80deg beta=80deg WhichAxis=Z)
  g_wb_14 [pec] = bondwire(WireType=LOW WireDiameter=0.015mm NumSides=6 XPadPos=0.000195 YPadPos=0.0028029412 ZPadPos=0 XDir=1 YDir=0 ZDir=0 Distance=0.00011 h1=0.00011 h2=0mm alpha=80deg beta=80deg WhichAxis=Z)
  g_wb_15 [pec] = bondwire(WireType=LOW WireDiameter=0.015mm NumSides=6 XPadPos=0.000195 YPadPos=0.0024264706 ZPadPos=0 XDir=1 YDir=0 ZDir=0 Distance=0.00011 h1=0.00011 h2=0mm alpha=80deg beta=80deg WhichAxis=Z)
  main [silicon] = box(corner=(-4.8e-05, 0.00154, -0.00028), size=(0.000596, 0.00742, 0.00028))
  sample_holder [vacuum] = box(corner=(-4.8e-05, 0.00154, -0.00165), size=(0.000596, 0.00742, 0.00254))
boundaries and excitations:
  PerfE: Perfect E Objects=[trace_feedline_02, launch_pad_p0, launch_pad_p2, ground_main_plane]
setups:
  Setup: HfssEigen MinimumFrequency=2GHz NumModes=2 MaxDeltaFreq=0.1 ConvergeOnRealFreq=true MaximumPasses=30 MinimumPasses=1 MinimumConvergedPasses=1 PercentRefinement=30 BasisOrder=1
source amplitudes:
  #-10:1: 1 0deg
  #-10:2: 0 0deg
field plots:
  Mag_E1: E Field over launch_pad_p2.face trace_feedline_02.face ground_main_plane.face(at (0.25, 5.25, 0)) launch_pad_p0.face on Setup : LastAdaptive at Phase=0deg
  ComplexMag_E1: E Field over launch_pad_p2.face trace_feedline_02.face launch_pad_p0.face on Setup : LastAdaptive at Phase=0deg
  Vector_E1: E Field over ground_main_plane.face(at (0.25, 5.25, 0)) on Setup : LastAdaptive at Phase=0deg
  trace_Vector_E2: E Field over trace_feedline_02.face on Setup : LastAdaptive at Phase=0deg
  trace_plus_pads_Vector_E2: E Field over trace_feedline_02.face launch_pad_p2.face launch_pad_p0.face on Setup : LastAdaptive at Phase=0deg
  trace_plus_pads_mesh: MeshPlots over launch_pad_p2.face trace_feedline_02.face launch_pad_p0.face on Setup : LastAdaptive at Phase=0deg
  ground_mesh: MeshPlots over ground_main_plane.face(at (0.25, 5.25, 0)) on Setup : LastAdaptive at Phase=0deg
  vaccum_mesh: MeshPlots in sample_holder on Setup : LastAdaptive at Phase=0deg
  silicon_mesh: MeshPlots in main on Setup : LastAdaptive at Phase=0deg
  wirebounds_Mag_E2: E Field over g_wb.face(all 20) g_wb_1.face(all 20) g_wb_2.face(all 20) g_wb_3.face(all 20) g_wb_4.face(all 20) g_wb_5.face(all 20) g_wb_6.face(all 20) g_wb_8.face(all 20) g_wb_7.face(all 20) g_wb_9.face(all 20) g_wb_10.face(all 20) g_wb_11.face(all 20) g_wb_12.face(all 20) g_wb_13.face(all 20) g_wb_14.face(all 20) g_wb_15.face(all 20) on Setup : LastAdaptive at Phase=0deg
  wirebonds_Vector_E2: E Field over g_wb.face(all 20) g_wb_1.face(all 20) g_wb_2.face(all 20) g_wb_3.face(all 20) g_wb_4.face(all 20) g_wb_5.face(all 20) g_wb_6.face(all 20) g_wb_7.face(all 20) g_wb_8.face(all 20) g_wb_9.face(all 20) g_wb_10.face(all 20) g_wb_11.face(all 20) g_wb_12.face(all 20) g_wb_13.face(all 20) g_wb_14.face(all 20) g_wb_15.face(all 20) on Setup : LastAdaptive at Phase=0deg
reports:
  Eigen Modes: re(Mode(1)), re(Mode(2)) vs Pass on Setup : AdaptivePass
  Solution Convergence: SolvedElements vs Pass on Setup : AdaptivePass
  Solution Convergence Plot1: log10(SolvedElements) vs Pass on Setup : AdaptivePass
  Solution Convergence Plot2: MaxDeltaFreq vs Pass on Setup : AdaptivePass
